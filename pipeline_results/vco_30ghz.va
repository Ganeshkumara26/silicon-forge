// Auto-generated Verilog-A model for 30GHz VCO
// Generated by SiliconForge 9-stage pipeline
// Timestamp: 2026-08-28T22:38:56.870998

`include "constants.vams"
`include "disciplines.vams"

module vco_30ghz_behavioral (out_p, out_n, vctrl, vdd);
    inout out_p, out_n, vctrl, vdd;
    electrical out_p, out_n, vctrl, vdd;

    parameter real f0 = 3.8184e+01 ; // Hz
    parameter real Vpp = 1.100 ; // V
    parameter real Q = 15.0 ;
    parameter real Kvco = 1e9 ; // Hz/V (typical)

    real phase, freq, vdiff;

    analog begin
        freq = f0 + Kvco * V(vctrl);
        phase = 2.0 * `M_PI * idt(freq);
        vdiff = Vpp * sin(phase);
        V(out_p) <+ V(vdd)/2.0 + vdiff/2.0;
        V(out_n) <+ V(vdd)/2.0 - vdiff/2.0;
    end
endmodule
