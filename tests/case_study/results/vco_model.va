// Auto-generated Verilog-A Oscillator Macro-Model
// Extracted f0: 10.2488 GHz
// Base Node: out_p
// Gamma_dc/Gamma_rms: 0.016563
// Generated by: PPV Solver Suite v2.0

`include "constants.vams"
`include "disciplines.vams"

module oscillator (out_p, out_n, vtune);
  electrical out_p, out_n, vtune;

  // Oscillator Properties
  parameter real f_nom = 1.024878e+10;   // Nominal frequency (Hz)
  parameter real T0 = 9.757262e-11;      // Nominal period (s)
  parameter real amp = 1.2;          // Output swing amplitude (V)
  parameter real Kvco = 5.000000e+08; // VCO gain (Hz/V)
  parameter real v_tune_nom = 0.6;   // Nominal tuning voltage (V)

  // PPV phase sensitivity vector (8 phases)
  real ppv[8];

  // State Variables
  real freq_inst;      // Instantaneous frequency
  real phase_inst;     // Integrated phase (via idt)
  real current_phase;  // Normalized phase [0, 1)
  integer phase_index; // Index into PPV array
  real noise_val;      // Random noise sample
  real phase_noise;    // Weighted phase noise contribution

  analog begin
    @(initial_step) begin
      ppv[0] = 4.300216e+09;
      ppv[1] = 7.684011e+10;
      ppv[2] = 1.449481e+11;
      ppv[3] = 6.236241e+10;
      ppv[4] = -3.940013e+09;
      ppv[5] = -6.717751e+10;
      ppv[6] = -1.388674e+11;
      ppv[7] = -6.707397e+10;
    end

    // 1. Calculate instantaneous frequency based on Vtune
    //    This properly tracks frequency modulation in closed-loop PLLs
    freq_inst = f_nom + Kvco * (V(vtune) - v_tune_nom);

    // 2. Integrate frequency to get continuous phase (idt accumulator)
    //    This guarantees phase continuity even with variable step sizes
    phase_inst = 2 * `M_PI * idt(freq_inst, 0);

    // 3. Map integrated phase to normalized [0, 1) for PPV lookup
    current_phase = phase_inst / (2 * `M_PI);
    current_phase = current_phase - floor(current_phase);

    // 4. Map to nearest extracted PPV array index
    phase_index = $rtoi(current_phase * 8);
    if (phase_index >= 8) phase_index = 8 - 1;
    if (phase_index < 0) phase_index = 0;

    // 5. Modulate jitter using cyclostationary phase sensitivity
    noise_val = $random() % 1000 / 1000.0;
    phase_noise = noise_val * 1.0e-15 * ppv[phase_index];

    // 6. Output differential signal with integrated phase noise
    V(out_p, out_n) <+ amp * sin(phase_inst + phase_noise);
  end
endmodule
